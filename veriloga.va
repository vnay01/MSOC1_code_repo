// VerilogA for VerilogALab, NAND1, veriloga

`include "constants.vams"
`include "disciplines.vams"

module NAND1(A,B,Y);

input A,B;
output Y;
electrical A,B,Y;

parameter real vlogic_high =1;
parameter real vlogic_low =0.0;
parameter real td =2n, tr=1n, tf=1n;
parameter real thresh =0.5;

analog begin :main

	integer logica, logicb, logicState;
//Detect transition for VA

 @(cross(V(A)-thresh,+1))
	if (V(A)> thresh)
		logica=1;
	else
			logica=0;

 @(cross(V(B)-thresh,+1))
	if (V(B)> thresh)
		logicb=1;
	else
			logicb=0;

 @(cross(V(A)-thresh,-1))
	if (V(A)> thresh)
		logica=1;
	else
			logica=0;

 @(cross(V(B)-thresh,-1))
	if (V(B)> thresh)
		logicb=1;
	else
			logicb=0;

	logicState= logica && logicb ? vlogic_low :vlogic_high;
	V(Y)<+ transition(logicState, td, tr, tf );

end

endmodule
