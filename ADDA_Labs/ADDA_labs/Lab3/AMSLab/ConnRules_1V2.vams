// Connect Rules file for connectLib/ConnRules_12V_full_fast1
// Generated by ADE.
// Cadence Design Systems, Inc.

// This is an autoGenerated file, any changes done to this file may get lost.

`include "disciplines.vams"
`include "userDisciplines.vams"

`define CONNRULES_18V_FULL_FAST
 `define CONNRULES_18V_FULL
 `define CONNRULES_18V_MID
 `define CONNRULES_18V_BASIC
 `define CONNRULES_FULL_FAST
 `define CONNRULES_FULL
 `define CONNRULES_MID
 `define CONNRULES_BASIC
 `define Vsup  1.8
 `define Vthi  1.2
 `define Vtlo  0.6
 `define Vlow  0
 `define Tr    0.2n
 `define Rlo   200
 `define Rhi   200
 `define Rx    40
 `define Rz    10M
 `define Vdelta      `Vsup/64
 `define Vdelta_tol  `Vdelta/4
 `define Tr_delta    `Tr/20

connectrules ConnRules_1V2_fast;
  connect L2E_2
      #( .vsup(1.2), .vlo(0), .tr(0.2n), .tf(0.2n), .rlo(200), .rhi(200), .rx(40), .rz(10M));
  connect E2L_2
      #( .vsup(1.2), .vthi(0.8), .vtlo(0.4), .tr(0.2n));
  connect Bidir_2
      #( .vsup(1.2), .vthi(0.8), .vtlo(0.4), .vlo(0), .tr(0.2n), .tf(0.2n), .rlo(200), .rhi(200), .rx(40), .rz(10M));
  connect E2R
      #( .vdelta(`Vsup/64), .vtol(`Vdelta/4), .ttol(`Tr/20));
  connect R2E_2
      #( .vsup(1.2), .vdelta(`Vsup/64), .tr(`Tr/20), .tf(`Tr/20), .rout(200));
  connect ER_bidir
      #( .vdelta(`Vsup/64), .vtol(`Vdelta/4), .ttol(`Tr/20), .tr(`Tr/20), .tf(`Tr/20), .rout(200), .rz(10M));
  connect L2E_2_CPF
      #( .vsup(1.2), .vlo(0), .tr(0.2n), .tf(0.2n), .rlo(200), .rhi(200), .rx(40), .rz(10M));
  connect Bidir_2_CPF
      #( .vsup(1.2), .vthi(0.8), .vtlo(0.4), .tr(0.2n), .tf(0.2n), .rlo(200), .rhi(200), .rx(40), .rz(10M));
endconnectrules
