// VerilogA for SpectreVerilog_VerA, Multiplier, veriloga

`include "constants.vams"
`include "disciplines.vams"

module Multiplier(in, out);
inout in;
electrical in;
inout out;
electrical out;
parameter real factor = 2.0;

analog begin
	??? <+ ???;
end

endmodule
