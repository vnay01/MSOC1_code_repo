  // VerilogA for SpectreVerilog_VerA, SampleToFile10, veriloga

`include "constants.vams"
`include "disciplines.vams"

module SampleToFile10(i1,i2,i3,i4,i5,i6,i7,i8,i9,i10,enable);

inout i1,i2,i3,i4,i5,i6,i7,i8,i9,i10;
input enable;
electrical i1,i2,i3,i4,i5,i6,i7,i8,i9,i10, enable;

parameter integer trigger = 1; 		// 1=rising edge, -1=falling edge
parameter real thresh = 1.65; 		// Trigger threshold level
parameter string fname = "samples.dat";	// Time between read points

integer of;

analog begin

@(initial_step) begin
	of = $fopen(fname, "w");
end

if (analysis("tran")) begin
	@(cross( V(enable)-thresh , trigger)) begin
//		$fstrobe(of, "%e %e %e %e %e %e %e %e %e %e %e",$abstime, V(i1),V(i2),V(i3),V(i4),V(i5),V(i6),V(i7),V(i8),V(i9),V(i10));
		$fstrobe(of, "%e %e %e",$abstime, V(i1),V(i2));
	end
end

@(final_step) begin
	$fclose(of);
end

end

endmodule
