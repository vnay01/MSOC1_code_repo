// VerilogA for SpectreVerilog_VerA, Comp, veriloga

`include "constants.vams"
`include "disciplines.vams"

module Comp(clk, in, ip, out);
inout clk;
electrical clk;
inout in;
electrical in;
inout ip;
electrical ip;
inout out;
electrical out;
parameter real voffset = 0.0; // input voltage offset
parameter real vl_h = 1.2;
parameter real vl_l = 0;
parameter real trise = 100e-12 ;
parameter real tdel = 100e-12 ;
parameter real tfall = 100e-12 ;

integer x;

analog begin

@(initial_step) begin
  x=1;
end

@(cross( V(clk) - (vl_h+vl_l)/2, +1 )) begin
   ???
end

V(out) <+ transition(x*vl_h, tdel, trise, tfall);

end

endmodule
