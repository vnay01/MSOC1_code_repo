// VerilogA for SpectreVerilog_VerA, DAC8Bit, veriloga

`include "constants.vams"
`include "disciplines.vams"

module DAC8Bit(DACOUT, RN, RP, b0, b1, b2, b3, b4, b5, b6, b7, clk);
inout DACOUT;
electrical DACOUT;
inout RN,RP;
electrical RN,RP;
inout b0, b1,b2,b3,b4,b5,b6,b7;
electrical b0,b1,b2,b3,b4,b5,b6,b7;
inout clk;
electrical clk;

real out,code,vrn,vrp;
real delay, rise,fall,thresh;

analog begin

@(initial_step) begin
	delay = 100p;
	rise = 500p;
	fall = 500p;
	thresh = 1.2/2;
	code = 0;
end

   @(cross( V(clk) - thresh, +1 )) begin
	code = 0;
	if (V(b7) > thresh) code = code + 128;
	if (V(b6) > thresh) code = code + 64;
	if (V(b5) > thresh) code = code + 32;
	if (V(b4) > thresh) code = code + 16;
	if (V(b3) > thresh) code = code + 8;
	if (V(b2) > thresh) code = code + 4;
	if (V(b1) > thresh) code = code + 2;
	if (V(b0) > thresh) code = code + 1;
   end

out = (V(RN) + ((V(RP)-V(RN))/256)*code);

V(DACOUT) <+ transition( out, delay, rise, fall );

end

endmodule
