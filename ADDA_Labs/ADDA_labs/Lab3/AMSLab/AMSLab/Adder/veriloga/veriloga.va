// VerilogA for SpectreVerilog_VerA, Adder, veriloga

`include "constants.vams"
`include "disciplines.vams"

module Adder(in1, in2, sum);
inout in1;
electrical in1;
inout in2;
electrical in2;
inout sum;
electrical sum;

analog begin
	??? <+ (???);
end

endmodule
