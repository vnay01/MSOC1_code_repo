// VerilogA for solns, SS, veriloga

`include "constants.vams"
`include "disciplines.vams"

module SS(out, ref);
inout out, ref;
electrical out, ref;
parameter real StartFreq = 1 from (0:inf);
parameter real HertzPerSecond = 1 from (0:inf);

    real curr_freq, phase, k_hz;

    analog begin

        curr_freq = StartFreq + HertzPerSecond * $abstime;
        phase = 2*`M_PI * idt(curr_freq,0);
        k_hz = curr_freq/1000;
        $bound_step(0.04/curr_freq);
        V(out, ref) <+ sin(phase);

    end

endmodule
